** Cell name: SARADC_CAP_MOM
.SUBCKT SARADC_CAP_MOM VSH FL VSS
Cmain VSH FL 1.879f
Cfl   FL  VSS 0.631f
Cvsh  VSH VSS 0.631f
.ENDS
